* XMEGA AWEX dead-time insertion demo
* ATxmega32A4U: TCC0 single-slope PWM + AWEXC with dead-time
* PC4 = DH0 (drive-high), PC5 = DL0 (drive-low)
* DH = same as WO, DL = inverted WO, dead-time = 20 cycles ~0.625us

.title vioavr atxmega32a4u awex dead-time co-simulation demo

.options reltol=1e-4 vntol=1e-6
.options method=trap

* dac_bridge converts digital to analog
A_dac4 [pc4_dig] [pc4_an] dac_bridge_model
A_dac5 [pc5_dig] [pc5_an] dac_bridge_model

.model dac_bridge_model dac_bridge(out_low=0.0 out_high=5.0 input_load=1e12)

* R_pull gives analog reference for digital nodes
R_pc4 pc4_dig 0 10k
R_pc5 pc5_dig 0 10k

* A-device: two vectors (24-element d_in, 24-element d_out)
* PORTA(0-7), PORTB(8-15), PORTC(16-23)
* Monitored: PC4(20), PC5(21) via dac_bridge
A_AVR [gnd gnd gnd gnd gnd gnd gnd gnd gnd gnd gnd gnd gnd gnd gnd gnd gnd gnd gnd gnd gnd gnd gnd gnd]
+      [gnd gnd gnd gnd gnd gnd gnd gnd gnd gnd gnd gnd gnd gnd gnd gnd gnd gnd gnd gnd pc4_dig pc5_dig gnd gnd]
+      d_cosim_model

.model d_cosim_model d_cosim(
+ simulation="./cosim/libavr_cosim.so"
+ sim_args=["atxmega32a4u","firmware.hex"]
+ queue_size=1024
+ irreversible=1
+ delay=1e-9
+)

.tran 1us 10u

.control
run
print v(pc4_an) v(pc5_an) > sim_matrix.log
plot v(pc4_an) v(pc5_an)
.endc

.end
