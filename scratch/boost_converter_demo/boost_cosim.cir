* Closed-loop Boost Converter Co-Simulation with ATmega328P
.title Boost Converter cosimulation

* 5V Power Supply Input
V_in vin 0 DC 5.0

* Boost Converter Power Stage
L1 vin switch 100u
D1 switch vout D_mod
.model D_mod d(is=1e-14 rs=0.05)

* Voltage-Controlled Switch modeling the MOSFET
S1 switch 0 gate_an 0 S_mod
.model S_mod sw(vt=2.5 vh=0.5 ron=0.05 roff=1meg)

* Output Capacitor (with ESR)
C1 vout_ideal 0 47u
R_esr vout vout_ideal 0.1

* Load Resistor (50 ohms)
R_load vout 0 50

* Feedback Voltage Divider (1/4 ratio: vfb = vout * 10k / (30k + 10k) = vout / 4)
* Regulating vfb to 2.5V will regulate vout to 10V.
R1 vout vfb 30k
R2 vfb 0 10k

* -------------------------------------------------------------
* Code Models and Bridges
* -------------------------------------------------------------

* DAC Bridge: Converts digital PB1 output (pin 1) to analog gate_an voltage
A_dac [pb1_dig] [gate_an] dac_bridge_model
.model dac_bridge_model dac_bridge(out_low=0.0 out_high=5.0 input_load=1e12)

* ADC Bridge: Injects analog feedback voltage vfb into AVR ADC Channel 0
A_adc vfb dummy adc_bridge_model
.model adc_bridge_model avr_adc_bridge(channel=0)
R_dummy dummy 0 1k

* d_cosim ATmega328P MCU
* Vector length is 32 pins. PB1 is at index 9 (PORTA=0..7, PORTB=8..15).
A_AVR [0 0 0 0 0 0 0 0  0 pb1_dig 0 0 0 0 0 0  0 0 0 0 0 0 0 0  0 0 0 0 0 0 0 0]
+     [0 0 0 0 0 0 0 0  0 pb1_dig 0 0 0 0 0 0  0 0 0 0 0 0 0 0  0 0 0 0 0 0 0 0]
+     d_cosim_model

.model d_cosim_model d_cosim(
+ simulation="./libavr_cosim.so"
+ sim_args=["atmega328p","firmware.hex"]
+ queue_size=1024 irreversible=1 delay=1e-9)

* -------------------------------------------------------------
* Simulation Controls
* -------------------------------------------------------------
.options reltol=0.005 method=gear trtol=7 chgtol=1e-13
.tran 1us 10ms

.control
run
* Plot/Print input, feedback, output, and gate drive voltages
print v(vin) v(vout) v(vfb) v(gate_an)
.endc
.end
