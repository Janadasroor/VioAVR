* Test: Mixed device types — ATmega328P (classic) + ATmega4809 (AVR8X)
R_pull1 pb0_dig 0 10k
R_pull2 pa0_dig 0 10k

A_1 [pb0_dig] [pb0_an 0] dac_model
A_2 [pa0_dig] [pa0_an 0] dac_model
.model dac_model dac_bridge(out_low=0.0 out_high=5.0 input_load=1e12)

* ATmega328P — PB0 at external ID 8 (d_out[8])
A_CLASSIC [0 0 0 0 0 0 0 0 0 0 0 0 0 0 0 0 0 0 0 0 0 0 0 0 0 0 0 0 0 0 0 0]
+ [0 0 0 0 0 0 0 0 pb0_dig 0 0 0 0 0 0 0 0 0 0 0 0 0 0 0 0 0 0 0 0 0 0 0]
+ cosim_classic

* ATmega4809 — PA0 at external ID 0 (d_out[0])
A_AVR8X [0 0 0 0 0 0 0 0 0 0 0 0 0 0 0 0 0 0 0 0 0 0 0 0 0 0 0 0 0 0 0 0]
+ [pa0_dig 0 0 0 0 0 0 0 0 0 0 0 0 0 0 0 0 0 0 0 0 0 0 0 0 0 0 0 0 0 0 0]
+ cosim_avr8x

.model cosim_classic d_cosim(simulation="./cosim/libavr_cosim.so" sim_args=["atmega328p","toggle.hex"] queue_size=1024 irreversible=1 delay=1e-9)
.model cosim_avr8x d_cosim(simulation="./cosim/libavr_cosim.so" sim_args=["atmega4809","toggle_avr8x.hex"] queue_size=1024 irreversible=1 delay=1e-9)

.options reltol=0.005 method=gear trtol=7 chgtol=1e-13
.tran 5us 300us
.control
run
print v(pb0_an) v(pa0_an)
.endc
.end
