* VioAVR AVR16EA28 GPIO Toggle Co-Simulation Demo (d_cosim)
* Toggles PORTA bit 0 with a delay loop at 16MHz.
* Check: pa0_an should show 5V square wave at ~400Hz (20000 cycles @ 16MHz)

A_dac [pa0_dig] [pa0_an] dac_bridge_model
.model dac_bridge_model dac_bridge(out_low=0.0 out_high=5.0 input_load=1e12)

R_pull pa0_dig 0 10k

A_AVR [0 0 0 0 0 0 0 0 0 0 0 0 0 0 0 0 0 0 0 0 0 0 0 0] [pa0_dig 0 0 0 0 0 0 0 pb0_dig 0 0 0 0 0 0 0 pc0_dig 0 0 0 0 0 0 0] d_cosim_model
.model d_cosim_model d_cosim(simulation="./cosim/libavr_cosim.so" sim_args=["avr16ea28","firmware.hex"] queue_size=1024 irreversible=1 delay=1e-9)

.tran 5us 10ms

.control
run
print v(pa0_an)
plot v(pa0_an)
.endc
.end
