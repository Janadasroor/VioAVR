* avr_adc_bridge co-simulation test
* Analog voltage injection via avr_adc_bridge -> VioAVR signal bank -> ADC
* ATmega3209 reads ADC channel 0, drives PA0 HIGH if > 2.5V (512/1024)

.title avr_adc_bridge co-sim test

.options reltol=1e-6 vntol=1e-6 method=trap

* Voltage source (variable analog input to test)
V_adc adc_in 0 DC 2.5

* avr_adc_bridge: reads adc_in voltage, injects into signal bank channel 0
A_avr_adc adc_in dummy avr_adc_bridge
.model avr_adc_bridge avr_adc_bridge(channel=0)
R_dummy dummy 0 1k

* d_cosim AVR (atmega3209, megaAVR-0)
* PORTA=ext 0-7, PORTB=ext 8-15, PORTC=ext 16-23
A_AVR [pa0_dig gnd gnd gnd gnd gnd gnd gnd
+        gnd gnd gnd gnd gnd gnd gnd gnd
+        gnd gnd gnd gnd gnd gnd gnd gnd]
+      [pa0_dig gnd gnd gnd gnd gnd gnd gnd
+        gnd gnd gnd gnd gnd gnd gnd gnd
+        gnd gnd gnd gnd gnd gnd gnd gnd]
+      d_cosim_model

.model d_cosim_model d_cosim(
+ simulation="./cosim/libavr_cosim.so"
+ sim_args=["atmega3209","firmware.hex","1"]
+ queue_size=1024 irreversible=1 delay=1e-9)

* DAC bridge: digital PA0 -> analog voltage for .print
A_dac [pa0_dig] [pa0_an 0] dac_bridge
.model dac_bridge dac_bridge(out_low=0 out_high=5 input_load=1p t_rise=1n t_fall=1n)

R_pull pa0_an 0 10k

.tran 1n 500u
.print tran v(adc_in) v(pa0_an)
.end
