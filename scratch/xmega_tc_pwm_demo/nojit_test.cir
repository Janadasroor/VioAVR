A_pd4 [pd4_dig] [pd4_an] dac_bridge_model
.model dac_bridge_model dac_bridge(out_low=0.0 out_high=5.0 input_load=1e12)
R_pull pd4_dig 0 10k
A_AVR [0 0 0 0 0 0 0 0 0 0 0 0 0 0 0 0 0 0 0 0 0 0 0 0 0 0 0 0 0 0 0 0] [0 0 0 0 0 0 0 0 0 0 0 0 0 0 0 0 0 0 0 0 0 0 0 0 0 0 0 0 pd4_dig 0 0 0] d_cosim_model
.model d_cosim_model d_cosim(simulation="./cosim/libavr_cosim.so" sim_args=["atxmega8e5","firmware.hex","0"] queue_size=1024 irreversible=1 delay=1e-9)
.tran 1us 100us
.control
run
print v(pd4_an) > /tmp/nojit.log
.endc
.end
