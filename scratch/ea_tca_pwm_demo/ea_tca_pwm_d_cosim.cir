* VioAVR AVR16EA28 TCA PWM Co-Simulation Demo (d_cosim)
* TCA0 single-slope PWM on PORTA bit 0, 16MHz, PER=255, CMP0=64
* PWM frequency = 16MHz / 255 = ~62.7kHz
* Duty cycle = 64/255 = ~25%

A_dac [pa0_dig] [pa0_an] dac_bridge_model
.model dac_bridge_model dac_bridge(out_low=0.0 out_high=5.0 input_load=1e12)

R_pull pa0_dig 0 10k

A_AVR [0 0 0 0 0 0 0 0 0 0 0 0 0 0 0 0 0 0 0 0 0 0 0 0] [pa0_dig 0 0 0 0 0 0 0 pb0_dig 0 0 0 0 0 0 0 pc0_dig 0 0 0 0 0 0 0] d_cosim_model
.model d_cosim_model d_cosim(simulation="./cosim/libavr_cosim.so" sim_args=["avr16ea28","firmware.hex"] queue_size=1024 irreversible=1 delay=1e-9)

.tran 1us 500us

.control
run
write sim_matrix.log v(pa0_an)
plot v(pa0_an)
.endc
.end
