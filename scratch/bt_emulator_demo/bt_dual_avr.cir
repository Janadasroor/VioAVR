* Two-chip BT emulator — two separate A-devices, cross-wired UART
* APP (ATmega4809): TXD=PA0(d_out[0]), RXD=PA1(d_in[1])
* BT  (ATmega4809): TXD=PA0(d_out[0]), RXD=PA1(d_in[1])

R_pull_app_txd app_txd 0 10k
R_pull_bt_txd  bt_txd  0 10k

A_dac_app [app_txd] [app_txd_an 0] dac_bridge
A_dac_bt  [bt_txd]  [bt_txd_an 0]  dac_bridge
.model dac_bridge dac_bridge(out_low=0.0 out_high=5.0 input_load=1e12)

* APP: d_in[1]=bt_txd (RXD=PA1), d_out[0]=app_txd (TXD=PA0)
A_APP [0 bt_txd 0 0 0 0 0 0 0 0 0 0 0 0 0 0 0 0 0 0 0 0 0 0 0 0 0 0 0 0 0 0]
+ [app_txd 0 0 0 0 0 0 0 0 0 0 0 0 0 0 0 0 0 0 0 0 0 0 0 0 0 0 0 0 0 0 0]
+ d_cosim_app

* BT: d_in[1]=app_txd (RXD=PA1), d_out[0]=bt_txd (TXD=PA0)
A_BT [0 app_txd 0 0 0 0 0 0 0 0 0 0 0 0 0 0 0 0 0 0 0 0 0 0 0 0 0 0 0 0 0 0]
+ [bt_txd 0 0 0 0 0 0 0 0 0 0 0 0 0 0 0 0 0 0 0 0 0 0 0 0 0 0 0 0 0 0 0]
+ d_cosim_bt

.model d_cosim_app d_cosim(simulation="./cosim/libavr_cosim.so" sim_args=["atmega4809","app.hex"] queue_size=1024 irreversible=1 delay=1e-9)
.model d_cosim_bt  d_cosim(simulation="./cosim/libavr_cosim.so" sim_args=["atmega4809","bt.hex"]  queue_size=1024 irreversible=1 delay=1e-9)

.options reltol=0.005 method=gear trtol=7 chgtol=1e-13
.tran 1u 5000u
.control
run
print v(app_txd_an) v(bt_txd_an)
.endc
.end
