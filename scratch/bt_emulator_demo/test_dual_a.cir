* Test: Two d_cosim A-devices with RTLD_LOCAL fix
R_pull1 a1_dig 0 10k
R_pull2 a2_dig 0 10k

A_first  [a1_dig] [a1_an 0] dac_bridge
A_second [a2_dig] [a2_an 0] dac_bridge

A_DEV1 [0 0 0 0 0 0 0 0 0 0 0 0 0 0 0 0 0 0 0 0 0 0 0 0]
+ [0 a1_dig 0 0 0 0 0 0 0 0 0 0 0 0 0 0 0 0 0 0 0 0 0 0]
+ d_cosim_1
A_DEV2 [0 0 0 0 0 0 0 0 0 0 0 0 0 0 0 0 0 0 0 0 0 0 0 0]
+ [0 a2_dig 0 0 0 0 0 0 0 0 0 0 0 0 0 0 0 0 0 0 0 0 0 0]
+ d_cosim_2

.model d_cosim_1 d_cosim(simulation="./cosim/libavr_cosim.so" sim_args=["atmega328p","firmware.hex"] queue_size=1024 irreversible=1)
.model d_cosim_2 d_cosim(simulation="./cosim/libavr_cosim.so" sim_args=["atmega328p","firmware.hex"] queue_size=1024 irreversible=1)
.model dac_bridge dac_bridge(out_low=0.0 out_high=5.0 input_load=1e12)

.options reltol=0.005 method=gear trtol=7 chgtol=1e-13
.tran 1u 100u
.control
run
print v(a1_an) v(a2_an)
.endc
.end
