* XSPICE multi-instance: 5 A-devices (N>4)
* Each device runs blinky firmware (PB5 toggle)
* Verify no SIGSEGV with 5+ instances

* Pull-up resistors for all PB5 digital nodes
R_pull1 pb5_d0 0 10k
R_pull2 pb5_d1 0 10k
R_pull3 pb5_d2 0 10k
R_pull4 pb5_d3 0 10k
R_pull5 pb5_d4 0 10k

* dac_bridge: digital -> analog
A_dac0 [pb5_d0] [pb5_an0 0] dac_bridge
A_dac1 [pb5_d1] [pb5_an1 0] dac_bridge
A_dac2 [pb5_d2] [pb5_an2 0] dac_bridge
A_dac3 [pb5_d3] [pb5_an3 0] dac_bridge
A_dac4 [pb5_d4] [pb5_an4 0] dac_bridge

* Device 1 (classic ATmega328P, PORTB5=ext ID 5)
A_DEV1 [0 0 0 0 0 0 0 0 0 0 0 0 0 0 0 0 0 0 0 0 0 0 0 0]
+ [0 0 0 0 0 pb5_d0 0 0 0 0 0 0 0 0 0 0 0 0 0 0 0 0 0 0]
+ d_cosim_1

* Device 2
A_DEV2 [0 0 0 0 0 0 0 0 0 0 0 0 0 0 0 0 0 0 0 0 0 0 0 0]
+ [0 0 0 0 0 pb5_d1 0 0 0 0 0 0 0 0 0 0 0 0 0 0 0 0 0 0]
+ d_cosim_2

* Device 3
A_DEV3 [0 0 0 0 0 0 0 0 0 0 0 0 0 0 0 0 0 0 0 0 0 0 0 0]
+ [0 0 0 0 0 pb5_d2 0 0 0 0 0 0 0 0 0 0 0 0 0 0 0 0 0 0]
+ d_cosim_3

* Device 4
A_DEV4 [0 0 0 0 0 0 0 0 0 0 0 0 0 0 0 0 0 0 0 0 0 0 0 0]
+ [0 0 0 0 0 pb5_d3 0 0 0 0 0 0 0 0 0 0 0 0 0 0 0 0 0 0]
+ d_cosim_4

* Device 5
A_DEV5 [0 0 0 0 0 0 0 0 0 0 0 0 0 0 0 0 0 0 0 0 0 0 0 0]
+ [0 0 0 0 0 pb5_d4 0 0 0 0 0 0 0 0 0 0 0 0 0 0 0 0 0 0]
+ d_cosim_5

.model d_cosim_1 d_cosim(simulation="./cosim/libavr_cosim.so" sim_args=["atmega328p","firmware.hex"] queue_size=1024 irreversible=1)
.model d_cosim_2 d_cosim(simulation="./cosim/libavr_cosim.so" sim_args=["atmega328p","firmware.hex"] queue_size=1024 irreversible=1)
.model d_cosim_3 d_cosim(simulation="./cosim/libavr_cosim.so" sim_args=["atmega328p","firmware.hex"] queue_size=1024 irreversible=1)
.model d_cosim_4 d_cosim(simulation="./cosim/libavr_cosim.so" sim_args=["atmega328p","firmware.hex"] queue_size=1024 irreversible=1)
.model d_cosim_5 d_cosim(simulation="./cosim/libavr_cosim.so" sim_args=["atmega328p","firmware.hex"] queue_size=1024 irreversible=1)
.model dac_bridge dac_bridge(out_low=0.0 out_high=5.0 input_load=1e12)

.options reltol=0.005 method=gear trtol=7 chgtol=1e-13
.tran 1u 50u
.control
run
print v(pb5_an0) v(pb5_an1) v(pb5_an2) v(pb5_an3) v(pb5_an4)
.exit 0
.endc
.end
