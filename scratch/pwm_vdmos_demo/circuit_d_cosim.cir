* VioAVR PWM-to-VDMOS Co-Simulation (d_cosim)
* Open-loop: 80kHz PWM on PB1, no ADC feedback

* Power Supplies
V_gate_supply  v12  0  DC 12.0
V_power_supply v24  0  DC 24.0

* DAC bridge for AVR Pin PB1 (external pin 1 = d_out[1])
A_mcu_bridge [pb1_dig] [pb1_an] dac_model
.model dac_model dac_bridge(out_low=0.0 out_high=5.0)

* BJT Gate Driver Circuit
R_base pb1_an base 1k
Q_driver gate_vdmos base 0 Q2N2222
R_pullup v12 gate_vdmos 470

* VDMOS Power Stage
M_power drain_vdmos gate_vdmos 0 0 IRF540
R_load v24 drain_vdmos 10

* AVR MCU via d_cosim (24 pins, d_in and d_out vectors)
* Pin index i -> PORT{B,C,D}[i%8] for i in 0..7,8..15,16..23
* PB1 is external_id=1 -> d_out[1], so PB1 must be at index 1 in both vectors
A_AVR [nc0 pb1_dig nc2 nc3 nc4 nc5 nc6 nc7 nc8 nc9 nc10 nc11 nc12 nc13 nc14 nc15 nc16 nc17 nc18 nc19 nc20 nc21 nc22 nc23] [nc0 pb1_dig nc2 nc3 nc4 nc5 nc6 nc7 nc8 nc9 nc10 nc11 nc12 nc13 nc14 nc15 nc16 nc17 nc18 nc19 nc20 nc21 nc22 nc23] d_cosim_model
.model d_cosim_model d_cosim(simulation="./cosim/libavr_cosim.so" sim_args=["atmega328p"] queue_size=1024 irreversible=1 delay=1e-9)

* Transistor Models
.model Q2N2222 NPN(Is=14.34f Xti=3 Eg=1.11 Vaf=74.03 Bf=255.9 Ne=1.307
+ Ise=14.34f Ikf=.2847 Xtb=1.5 Br=6.092 Nc=2 Isc=0 Ikr=0 Rc=1
+ Cjc=7.306p Mjc=.3416 Vjc=.75 Fc=.5 Cje=22.01p Mje=.377 Vje=.75
+ Tr=46.91n Tf=411.1p Itf=.6 Vtf=1.7 Xtf=3 Rb=10)

.model IRF540 VDMOS(Rg=1.0 Vto=3.0 Rd=40m Rs=10m Rb=20m Kp=8.0 Lambda=10m
+ Cgdmax=1.0n Cgdmin=0.1n Cgs=1.5n Cds=0.5n Is=1e-12 Q=1.5)

* Solver Options
.options reltol=0.005 method=gear trtol=7 chgtol=1e-13
.tran 1us 0.5ms

.control
run
print v(pb1_an) v(gate_vdmos) v(drain_vdmos)
.endc
.end
