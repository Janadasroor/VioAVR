* Multi-MCU Co-Simulation Demo
* Master: ATmega4809 (TWI master, ADC sensor read)
* Slave:  ATmega328P (bit-banged I2C slave, R-2R DAC out)
*
* One d_cosim A-device, 64 d_in + 64 d_out:
*   Chip 0 (master 4809): global IDs  0-31
*   Chip 1 (slave  328P): global IDs 32-63
*
* I2C bus: master SDA/SCL on PA2/PA3 (ext 2/3)
*          slave  SDA/SCL on PD1/PD0 (ext 25/24)
*          10kΩ pull-ups to 5V (pins_initialized sets HI_IMPEDANCE at first step)
* R-2R DAC: slave PORTB (ext 8-15) -> R-2R ladder -> v_dac_out
* ADC sensor: V_sine -> avr_adc_bridge -> master AIN0

* === Analog sensor: 10Hz sine wave 0..5V ===
V_sig v_sig 0 SINE(0 5 10)
R_sig_load v_sig 0 1MEG

* === ADC bridge: inject sensor into master's signal bank (ch 0) ===
A_adc v_sig dummy_adc avr_adc_bridge
.model avr_adc_bridge avr_adc_bridge(channel=0)
R_dummy_adc dummy_adc 0 1k

* === 5V supply ===
V_supply 5v 0 DC 5.0

* === I2C bus pull-ups to 5V ===
* 10kΩ: pins_initialized at first step sets d_out to HI_IMPEDANCE,
* so the bus floats to 5V when no chip drives it. When a chip drives
* LOW, the hybrid's output impedance (~2.3kΩ) gives Vbus ≈ 0.01V.
R_sda_pull v_sda 5v 10k
R_scl_pull v_scl 5v 10k

* === R-2R ladder DAC (8-bit, R=10k, 2R=20k) ===
* Slave PORTB = chip 1 ext IDs 8-15 = global d_out[40..47]
* 1MEG pull-downs on PB pins define 0V when pins are HI-IMPEDANCE (input)
R_b0 pb0_dig v_j0 20k
R_pd0 pb0_dig 0 1MEG
R_b1 pb1_dig v_j1 20k
R_pd1 pb1_dig 0 1MEG
R_b2 pb2_dig v_j2 20k
R_pd2 pb2_dig 0 1MEG
R_b3 pb3_dig v_j3 20k
R_pd3 pb3_dig 0 1MEG
R_b4 pb4_dig v_j4 20k
R_pd4 pb4_dig 0 1MEG
R_b5 pb5_dig v_j5 20k
R_pd5 pb5_dig 0 1MEG
R_b6 pb6_dig v_j6 20k
R_pd6 pb6_dig 0 1MEG
R_b7 pb7_dig v_j7 20k
R_pd7 pb7_dig 0 1MEG
R_s0 v_j0 v_j1 10k
R_s1 v_j1 v_j2 10k
R_s2 v_j2 v_j3 10k
R_s3 v_j3 v_j4 10k
R_s4 v_j4 v_j5 10k
R_s5 v_j5 v_j6 10k
R_s6 v_j6 v_j7 10k
R_s7 v_j7 v_dac_out 10k
R_term v_dac_out 0 20k

* === dac_bridge monitors analog nodes for waveform visualization ===
* I2C bus uses dac_bridge_i2c with out_undef=5.0 so undriven nodes read 5V
A_dac_sda  [v_sda]      [v_a_sda 0]    dac_bridge_i2c
A_dac_scl  [v_scl]      [v_a_scl 0]    dac_bridge_i2c
A_dac_dac  [v_dac_out]  [v_a_dac 0]    dac_bridge_model
.model dac_bridge_model dac_bridge(out_low=0.0 out_high=5.0 input_load=1e12)
.model dac_bridge_i2c dac_bridge(out_low=0.0 out_high=5.0 out_undef=5.0 input_load=1e12)

* === One d_cosim A-device, 64 d_in + 64 d_out ===
* d_in  (chip0 local 0-31, chip1 local 32-63):
*   chip0 [0..1]=0  [2]=v_sda [3]=v_scl [4..31]=0
*   chip1 [32..39]=0  [40..47]=pb0..7_dig [48..55]=0
*   chip1 [56]=v_scl [57]=v_sda [58..63]=0
* d_out (same layout):
*   chip0 [2]=v_sda [3]=v_scl
*   chip1 [40..47]=pb0..7_dig [56]=v_scl [57]=v_sda
A_DUAL
+ [0 0 v_sda v_scl 0 0 0 0 0 0 0 0 0 0 0 0 0 0 0 0 0 0 0 0 0 0 0 0 0 0 0 0
+ 0 0 0 0 0 0 0 0 pb0_dig pb1_dig pb2_dig pb3_dig pb4_dig pb5_dig pb6_dig pb7_dig
+ 0 0 0 0 0 0 0 0 v_scl v_sda 0 0 0 0 0 0]
+ [0 0 v_sda v_scl 0 0 0 0 0 0 0 0 0 0 0 0 0 0 0 0 0 0 0 0 0 0 0 0 0 0 0 0
+ 0 0 0 0 0 0 0 0 pb0_dig pb1_dig pb2_dig pb3_dig pb4_dig pb5_dig pb6_dig pb7_dig
+ 0 0 0 0 0 0 0 0 v_scl v_sda 0 0 0 0 0 0]
+ d_cosim_dual

.model d_cosim_dual d_cosim(simulation="./cosim/libavr_cosim.so"
+ sim_args=["atmega4809","master.hex","atmega328p","slave.hex"]
+ queue_size=1024 irreversible=1 delay=1e-9)

* === Simulation control ===
.control
tran 200n 5m
set width=120
print v(v_dac_out) v(v_sig) v(v_sda) v(v_scl) > sim_matrix.log
.endc
