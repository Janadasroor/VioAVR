* Test with .codemodel in netlist
.codemodel /home/jnd/cpp_projects/VioMATRIXC/release/src/xspice/icm/digital/digital.cm
.codemodel /home/jnd/cpp_projects/VioMATRIXC/release/src/xspice/icm/analog/analog.cm
.codemodel /home/jnd/cpp_projects/VioAVR/build/cosim/avr_adc_bridge.cm

V_sin ain_sig 0 SIN(0 5 1000)
A_adc_bridge ain_sig dummy avr_adc_bridge_model
.model avr_adc_bridge_model avr_adc_bridge(channel=0)
R_dummy dummy 0 1k

R_pull pc1_dig 0 10k
A_dac [pc1_dig] [pc1_an 0] dac_bridge_model
.model dac_bridge_model dac_bridge(out_low=0 out_high=5 input_load=1e12)

A_AVR [0 0 0 0 0 0 0 0 0 0 0 0 0 0 0 0 0 0 0 0 0 0 0 0 0 0 0 0 0 0 0 0]
      [0 0 0 0 0 0 0 0 0 0 0 0 0 0 0 0 0 pc1_dig 0 0 0 0 0 0 0 0 0 0 0 0 0 0]
      d_cosim_model
.model d_cosim_model d_cosim(simulation="./cosim/libavr_cosim.so" sim_args=["atmega4809","firmware.hex","1"] queue_size=1024 irreversible=1 delay=1e-9)

.tran 1u 3m
.control
run
print v(pc1_an)
.endc
.end
