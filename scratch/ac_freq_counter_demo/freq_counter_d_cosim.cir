* VioAVR AC0 -> EVSYS -> TCB0 frequency counter demo (ATmega4809)
* 1kHz sine wave on signal bank ch0 via avr_adc_bridge
* AC0 compares AINP0 vs DACREF=128 (~2.5V->50% duty)
* AC0 rising edges -> EVSYS -> TCB0 captures, ISR writes CCMPH to PORTC

.options reltol=1e-6 vntol=1e-6 method=trap

* 1kHz sine wave: 0V offset, 5V amplitude -> 0V-5V swing
V_sin ain_sig 0 SIN(0 5 1000)

* Inject analog voltage into signal bank channel 0
A_adc_bridge ain_sig dummy avr_adc_bridge_model
.model avr_adc_bridge_model avr_adc_bridge(channel=0)
R_dummy dummy 0 1k

* PORTC (ext IDs 16-23) all 8 pins
A_dac [pc0_dig pc1_dig pc2_dig pc3_dig pc4_dig pc5_dig pc6_dig pc7_dig] [pc0_an pc1_an pc2_an pc3_an pc4_an pc5_an pc6_an pc7_an] dac_bridge_model
.model dac_bridge_model dac_bridge(out_low=0 out_high=5 input_load=1e12)

R_pc0 pc0_dig 0 10k
R_pc1 pc1_dig 0 10k
R_pc2 pc2_dig 0 10k
R_pc3 pc3_dig 0 10k
R_pc4 pc4_dig 0 10k
R_pc5 pc5_dig 0 10k
R_pc6 pc6_dig 0 10k
R_pc7 pc7_dig 0 10k

* AVR: PORTC = ext IDs 16-23
A_AVR [0 0 0 0 0 0 0 0 0 0 0 0 0 0 0 0 0 0 0 0 0 0 0 0 0 0 0 0 0 0 0 0] [0 0 0 0 0 0 0 0 0 0 0 0 0 0 0 0 pc0_dig pc1_dig pc2_dig pc3_dig pc4_dig pc5_dig pc6_dig pc7_dig 0 0 0 0 0 0 0 0] d_cosim_model

.model d_cosim_model d_cosim(simulation="./cosim/libavr_cosim.so" sim_args=["atmega4809","firmware.hex","1"] queue_size=1024 irreversible=1 delay=1e-9)

.tran 1u 1m

.control
run
print v(pc0_an) v(pc1_an)
.endc

.end
