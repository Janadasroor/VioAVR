.title Simple PA0 High

A_dac [pa0_dig] [pa0_an] dac_bridge
.model dac_bridge dac_bridge(out_low=0 out_high=5)
R_p pa0_dig 0 10k

A_AVR [0 0 0 0 0 0 0 0 0 0 0 0 0 0 0 0 0 0 0 0 0 0 0 0 0 0 0 0 0 0 0 0]
+      [pa0_dig 0 0 0 0 0 0 0 0 0 0 0 0 0 0 0 0 0 0 0 0 0 0 0 0 0 0 0 0 0 0 0 0]
+      d_cosim_model

.model d_cosim_model d_cosim(
+ simulation="./cosim/libavr_cosim.so"
+ sim_args=["atmega4809","simple.hex","0"]
+ queue_size=1024 irreversible=1 delay=1e-9)

.tran 1us 200us

.control
run
print v(pa0_an)
.endc
.end
