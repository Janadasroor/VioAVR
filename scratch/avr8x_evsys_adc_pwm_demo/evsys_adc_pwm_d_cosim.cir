* VioAVR ATmega4809 EVSYS->ADC->PWM Closed-Loop Demo
*
* Demonstrates:
*   1. EVSYS: TCA0 overflow event triggers ADC conversion
*   2. ADC: event-triggered on EVSYS, reads analog voltage via sim_args
*   3. TCA: single-slope PWM on PB0, duty updated by ADC result in ISR
*   4. Interrupt-driven control loop (no polling in ISR path)
*
* Pin mapping (AVR8X megaAVR-0, 32-pin vectors):
*   PB0 (ext 8)  = TCA0 WO0 PWM output (via PORTMUX ALT1)
*   PC0 (ext 16) = Heartbeat toggle (blinks when firmware runs)

.title EVSYS->ADC->PWM Closed-Loop Demo

.options reltol=1e-6 vntol=1e-6 method=trap

* DAC bridges: monitor PB0 (PWM) and PC0 (heartbeat)
A_dac [pb0_dig pc0_dig] [pb0_an pc0_an] dac_bridge
.model dac_bridge dac_bridge(out_low=0 out_high=5 input_load=1p t_rise=1n t_fall=1n)

R_p_pwm pb0_dig 0 10k
R_p_hb  pc0_dig 0 10k

* d_cosim AVR: 32-pin vectors (PORTA=0-7, PORTB=8-15, PORTC=16-23, PORTD=24-31)
* 4th sim_args arg "3.0" injects 3.0V on signal bank channel 0 (AIN0)
A_AVR [0 0 0 0 0 0 0 0
+       pb0_dig 0 0 0 0 0 0 0
+       pc0_dig 0 0 0 0 0 0 0
+       0 0 0 0 0 0 0 0]
+      [0 0 0 0 0 0 0 0
+       pb0_dig 0 0 0 0 0 0 0
+       pc0_dig 0 0 0 0 0 0 0
+       0 0 0 0 0 0 0 0]
+      d_cosim_model

.model d_cosim_model d_cosim(
+ simulation="./cosim/libavr_cosim.so"
+ sim_args=["atmega4809","firmware.hex","0","3.0"]
+ queue_size=1024 irreversible=1 delay=1e-9)

.tran 5us 1ms

.control
run
print v(pb0_an) v(pc0_an) > sim_matrix.log
plot v(pb0_an) v(pc0_an)
.endc

.end
