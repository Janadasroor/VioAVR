* VioAVR ATxmega8E5 IRCOM Co-Simulation Demo (d_cosim)
* - IRCOM TX enabled, carrier ~80kHz (TXPLCTRL=100, 16MHz)
* - Output on PORTA bit 0 = ext_id 0 = pa0_dig
* PORTA=0-7, PORT[C]=16-23 (letter-based idx=2), PORTD=24-31 (idx=3)
*
* Firmware also configures PORTA bit 0 as output and PORTD bit 6 as output
* for manual verification.

* dac_bridge: digital PORTA bit 0 -> analog pa0_an
A_pa0 [pa0_dig] [pa0_an] dac_bridge_model
.model dac_bridge_model dac_bridge(out_low=0.0 out_high=5.0 input_load=1e12)

R_pull_pa0 pa0_dig 0 10k

* d_cosim: 32-element vectors, d_out[0] = PORTA bit 0 = pa0_dig
A_AVR [0 0 0 0 0 0 0 0 0 0 0 0 0 0 0 0 0 0 0 0 0 0 0 0 0 0 0 0 0 0 0 0] [pa0_dig 0 0 0 0 0 0 0 0 0 0 0 0 0 0 0 0 0 0 0 0 0 0 0 0 0 0 0 0 0 0 0] d_cosim_model
.model d_cosim_model d_cosim(simulation="./cosim/libavr_cosim.so" sim_args=["atxmega8e5","firmware.hex"] queue_size=1024 irreversible=1 delay=1e-9)

.tran 1us 5ms

.control
run
print v(pa0_an) v(pa0_dig) > sim_matrix.log
plot v(pa0_an)
.endc
.end
