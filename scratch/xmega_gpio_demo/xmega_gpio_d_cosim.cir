* VioAVR ATxmega8E5 GPIO Toggle Co-Simulation Demo (d_cosim)
* Toggles PORTA bit 0 with a delay loop at 32MHz.
* Check: pa0_an should show 5V square wave

A_dac [pa0_dig] [pa0_an] dac_bridge_model
.model dac_bridge_model dac_bridge(out_low=0.0 out_high=5.0 input_load=1e12)

R_pull pa0_dig 0 10k

A_AVR [gnd gnd gnd gnd gnd gnd gnd gnd gnd gnd gnd gnd gnd gnd gnd gnd gnd gnd gnd gnd gnd gnd gnd gnd] [pa0_dig gnd gnd gnd gnd gnd gnd gnd gnd gnd gnd gnd gnd gnd gnd gnd gnd gnd gnd gnd gnd gnd gnd gnd] d_cosim_model
.model d_cosim_model d_cosim(simulation="./cosim/libavr_cosim.so" sim_args=["atxmega8e5","firmware.hex"] queue_size=1024 irreversible=1 delay=1e-9)

.tran 5us 10ms

.control
run
print v(pa0_an)
plot v(pa0_an)
.endc
.end
