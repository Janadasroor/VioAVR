.control
devhelp adc_bridge
quit
.endc
.end
